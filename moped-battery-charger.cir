* Qucs 25.2.0  /storage2/home-tp/fossil/electronics-web/qucks-s/moped-battery-charger.sch
.INCLUDE "/usr/local/share/qucs-s/xspice_cmlib/include/ngspice_mathfunc.inc"

* TL431 Current Regulator
.subckt nTL431 CATHODE ANODE REF
Q1 N004 N003 N001 0 P
Q2 ANODE N002 N001 0 P
Q3 CATHODE N005 ANODE 0 N
R1 N002 ANODE 600k
R2 REF N002 648k
I1 CATHODE N001 5u
V1 N003 ANODE 1.2V
Q4 CATHODE N004 N005 0 N
R6 N004 ANODE 640k
.model N NPN(BF=250 Cje=.5p Cjc=.5p Rb=500)
.model P PNP(BF=120 Cje=.3p Cjc=1.5p Rb=250)
.ends TL431

.SUBCKT VoltageReferences_TL431  gnd _net0 _net1 _net2
X1 _net0 _net1 _net2 nTL431
.ENDS

* Motorola 2N1595 50 Volt 1.6 Amp SCR
*    TERMINALS:  A G K
.SUBCKT X2N1595  1 2 3
QP  6 4 1  POUT
QN  4 6 5  NOUT
RF  6 4    10MEG
RR  1 4    6.66MEG
RGK 6 5    210
RG  2 6    92.9
RK  3 5    80M
DF  6 4    ZF
DR  1 4    ZR
DGK 6 5    ZGK
.MODEL ZF   D (IS=.64F IBV=1U BV=50 RS=1.5MEG)
.MODEL ZR   D (IS=.64F IBV=1U BV=66.6)
.MODEL ZGK  D (IS=.64F IBV=1U BV=10)
.MODEL POUT PNP (IS=640F BF=1 CJE=335P)
.MODEL NOUT NPN (IS=640F BF=100 RC=.32
+ CJE=335P CJC=67P TF=143N TR=17U)
.ENDS

.SUBCKT Thyristor_2N1595  gnd _net0 _net1 _net2
X1 _net0 _net1 _net2 X2N1595
.ENDS

XTL431 0 _net0 0 ref VoltageReferences_TL431
R2 ref generator  10K tc1=0.0 tc2=0.0
R3 0 ref  2.2K tc1=0.0 tc2=0.0
R4 _net0 _net1  10K tc1=0.0 tc2=0.0
Vbattery _net2 0 DC 12.6
QT_2N2907_1 _net3 _net1 generator QMOD_T_2N2907_1 AREA=1.0
.MODEL QMOD_T_2N2907_1 pnp (Is=1E-14 Nf=1 Nr=1 Ikf=0.3 Ikr=0 Vaf=120 Var=0 Ise=0 Ne=1.5 Isc=0 Nc=2 Bf=250 Br=3 Rbm=0 Irb=0 Rc=3 Re=1 Rb=10 Cje=30E-12 Vje=0.75 Mje=0.33 Cjc=8E-12 Vjc=0.75 Mjc=0.33 Xcjc=1.0 Cjs=0 Vjs=0.75 Mjs=0 Fc=0.5 Tf=400E-12 Xtf=3 Vtf=2 Itf=1 Tr=100E-9 Kf=0.0 Af=1.0 Ptf=0.0 Xtb=0.0 Xti=3.0 Eg=1.11 Tnom=26.85 )
XSCR 0 generator _net4 0 Thyristor_2N1595
V2 _net5 0 DC 0 SIN(0 17 1K 0 0 0) AC 17 ACPHASE 0
R8 _net1 generator  1K tc1=0.0 tc2=0.0
D1N5711_1 generator _net2 DMOD_D1N5711_1 AREA=1
.MODEL DMOD_D1N5711_1 D (Is=315N N=2.03 Cj0=2P M=0.333 Vj=0.7 Fc=0.5 Rs=2.8 Tt=1.44N Kf=0 Af=1 Bv=70 Ibv=10U Xti=3 Eg=1.11 Tcv=0 Trs=0 Ttt1=0 Ttt2=0 Tm1=0 Tm2=0 Tnom=26.85 )
RLimiting_Resistor_10W _net5 generator  5 tc1=0.0 tc2=0.0
R9 0 _net4  1K tc1=0.0 tc2=0.0
R10 _net3 _net4  4.7K tc1=0.0 tc2=0.0

.control

tran 2.5025e-07 0.002 0
write spice4qucs.tr1.plot v(generator) v(ref)
destroy all
reset

op
print v(generator) v(ref)   > spice4qucs.dc1.ngspice.dc.print
destroy all
reset

exit
.endc
.END
