** sch_path: /home/4tb/fossil/schematics/lm324-xover-distort.sch
**.subckt lm324-xover-distort
r1 sigout VSS 1k m=1
c1 sigout VSS 1n m=1
* noconn sigin
* noconn VCC
r2 VCC sigout 1k m=1
V1 VCC 0 10
V2 0 VSS 10
x1 sigin sigout VCC VSS sigout lm324
**** begin user architecture code

.option RUNLVL=5 post
.temp  25
.include lm324.mod
vp sigin 0 pwl 0 0 100n 2 200u 2 201u 3 400u 3 401u -5

.control
tran 0.1u 500u
run
plot sigin sigout
rusage all
write lm324-xover-distort.raw
** quit 0
.endc

**** end user architecture code
**.ends
.end
